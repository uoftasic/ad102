* AD102 Lab 03 -- the same RC, seen in the frequency domain
*
* Exactly the devices from part E of spice/rc.spice -- 30.3315 um of
* high-sheet poly and a 22.1965 um square of MiM, no ideal components
* anywhere -- but asked a different question.
*
* rc.spice steps the input and times the response. This deck wiggles the
* input at every frequency from 100 kHz to 10 GHz and asks where the output
* stops keeping up. The two measurements are the same fact:
*
*     f_-3dB = 1 / (2 * pi * tau)
*
* and if your tau and your f_-3dB do not satisfy that to three or four
* figures, one of the two decks is wrong. That check is free; make it a habit.
*
* AD101 read this kind of plot for IDEAL R and C. Here it is again, built
* out of a shape you designed, over the same values drawn ideal.
*
* W and L are PLAIN MICRON NUMBERS -- never W=1u.
*
* This deck loads the same sky130.lib.spice tt corner as rc.spice, so it is
* just as slow to start. It was written for a pre-flattened copy of that
* corner, about thirty times quicker to read, which the 2026.08 image does
* not ship.

.lib /foss/pdks/sky130A/libs.tech/ngspice/sky130.lib.spice tt

* ---- the real one: your Lab 01 resistor and your Lab 02 capacitor
Vr in 0 dc 0 ac 1
Xr in out 0 sky130_fd_pr__res_high_po W=1 L=30.3315
Xc out 0 sky130_fd_pr__cap_mim_m3_1 W=22.1965 L=22.1965

* ---- an ideal 10k and 1p (section B of rc.spice), for the overlay
Vi ini 0 dc 0 ac 1
Ri ini outi 10k
Ci outi 0 1p

.control
ac dec 200 1e5 1e10
wrdata results/bode.txt vdb(out) vdb(outi) vp(out) vp(outi)

meas ac f3db_real  when vdb(out)=-3.0103  fall=1
meas ac f3db_ideal when vdb(outi)=-3.0103 fall=1
meas ac ph_real    find vp(out)  at=1.5857e7
echo
echo "--- decade of roll-off: the real filter, dB at 10x the corner ---"
meas ac g_10x find vdb(out) at=1.5857e8
.endc
.end
