* AD102 Lab 01 -- my_resistor.spice   <-- THIS IS THE FILE YOU EDIT
*
* Two resistors to size. Change ONLY the two L= numbers.
*
*   R1 : 2.2 kohm, drawn in sky130_fd_pr__res_high_po  at W = 1 um
*   R2 :  50 kohm, drawn in sky130_fd_pr__res_xhigh_po at W = 1 um
*
* The values shipped below are the NAIVE answers -- length straight from the
* sheet resistance printed on each model card, with no end resistance:
*
*   R1 : L = 2200 / 317.3885 = 6.9315 um     (card says 317.3885 ohm/square)
*   R2 : L = 50000 / 2000    = 25.0000 um    (card says 2000 ohm/square)
*
* Run `make mine` with these and read the FAIL. Then use the two numbers
* `make sheet` extracted for you and size them properly.
*
* PASS is within 1 % of target. Nothing else in this file needs to change.

.lib /foss/pdks/sky130A/libs.tech/ngspice/sky130.lib.spice tt

I1 0 r1 dc 1u
X1 r1 0 0 sky130_fd_pr__res_high_po  W=1 L=6.9315
*                                          ^^^^^^ R1: 2.2 kohm goes here

I2 0 r2 dc 1u
X2 r2 0 0 sky130_fd_pr__res_xhigh_po W=1 L=25.0000
*                                          ^^^^^^^ R2: 50 kohm goes here

.control
op
let r_mine1 = v(r1)/1u
let r_mine2 = v(r2)/1u
echo "--- your two resistors (ohms) ---"
print r_mine1 r_mine2
.endc
.end
